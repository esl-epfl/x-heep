// Copyright EPFL contributors.
// Licensed under the Apache License, Version 2.0, see LICENSE for details.
// SPDX-License-Identifier: Apache-2.0
{ name: "pad_control",
  clock_primary: "clk_i",
  bus_interfaces: [
    { protocol: "reg_iface", direction: "device" }
  ],
  regwidth: "32",
  registers: [

    { name:     "PAD_MUX_EXIT_VALID",
      desc:     "Used to mux pad EXIT_VALID",
      resval:   "0x0"
      swaccess: "rw",
      hwaccess: "hro",
      fields: [
        { bits: "3:0", name: "PAD_MUX_EXIT_VALID", desc: "Pad Mux EXIT_VALID Reg" }
      ]
    }


    { name:     "PAD_ATTRIBUTE_CLK",
      desc:     "clk Attributes (Pull Up En, Pull Down En, etc. It is technology specific.",
      resval:   "0x00"
      swaccess: "rw",
      hwaccess: "hro",
      fields: [
        { bits: "7:0", name: "PAD_ATTRIBUTE_CLK", desc: "Pad Attribute CLK Reg" }
      ]
    }

    { name:     "PAD_ATTRIBUTE_RST",
      desc:     "rst Attributes (Pull Up En, Pull Down En, etc. It is technology specific.",
      resval:   "0x00"
      swaccess: "rw",
      hwaccess: "hro",
      fields: [
        { bits: "7:0", name: "PAD_ATTRIBUTE_RST", desc: "Pad Attribute RST Reg" }
      ]
    }

    { name:     "PAD_ATTRIBUTE_BOOT_SELECT",
      desc:     "boot_select Attributes (Pull Up En, Pull Down En, etc. It is technology specific.",
      resval:   "0x00"
      swaccess: "rw",
      hwaccess: "hro",
      fields: [
        { bits: "7:0", name: "PAD_ATTRIBUTE_BOOT_SELECT", desc: "Pad Attribute BOOT_SELECT Reg" }
      ]
    }

    { name:     "PAD_ATTRIBUTE_EXECUTE_FROM_FLASH",
      desc:     "execute_from_flash Attributes (Pull Up En, Pull Down En, etc. It is technology specific.",
      resval:   "0x00"
      swaccess: "rw",
      hwaccess: "hro",
      fields: [
        { bits: "7:0", name: "PAD_ATTRIBUTE_EXECUTE_FROM_FLASH", desc: "Pad Attribute EXECUTE_FROM_FLASH Reg" }
      ]
    }

    { name:     "PAD_ATTRIBUTE_JTAG_TCK",
      desc:     "jtag_tck Attributes (Pull Up En, Pull Down En, etc. It is technology specific.",
      resval:   "0x00"
      swaccess: "rw",
      hwaccess: "hro",
      fields: [
        { bits: "7:0", name: "PAD_ATTRIBUTE_JTAG_TCK", desc: "Pad Attribute JTAG_TCK Reg" }
      ]
    }

    { name:     "PAD_ATTRIBUTE_JTAG_TMS",
      desc:     "jtag_tms Attributes (Pull Up En, Pull Down En, etc. It is technology specific.",
      resval:   "0x00"
      swaccess: "rw",
      hwaccess: "hro",
      fields: [
        { bits: "7:0", name: "PAD_ATTRIBUTE_JTAG_TMS", desc: "Pad Attribute JTAG_TMS Reg" }
      ]
    }

    { name:     "PAD_ATTRIBUTE_JTAG_TRST",
      desc:     "jtag_trst Attributes (Pull Up En, Pull Down En, etc. It is technology specific.",
      resval:   "0x00"
      swaccess: "rw",
      hwaccess: "hro",
      fields: [
        { bits: "7:0", name: "PAD_ATTRIBUTE_JTAG_TRST", desc: "Pad Attribute JTAG_TRST Reg" }
      ]
    }

    { name:     "PAD_ATTRIBUTE_JTAG_TDI",
      desc:     "jtag_tdi Attributes (Pull Up En, Pull Down En, etc. It is technology specific.",
      resval:   "0x00"
      swaccess: "rw",
      hwaccess: "hro",
      fields: [
        { bits: "7:0", name: "PAD_ATTRIBUTE_JTAG_TDI", desc: "Pad Attribute JTAG_TDI Reg" }
      ]
    }

    { name:     "PAD_ATTRIBUTE_JTAG_TDO",
      desc:     "jtag_tdo Attributes (Pull Up En, Pull Down En, etc. It is technology specific.",
      resval:   "0x00"
      swaccess: "rw",
      hwaccess: "hro",
      fields: [
        { bits: "7:0", name: "PAD_ATTRIBUTE_JTAG_TDO", desc: "Pad Attribute JTAG_TDO Reg" }
      ]
    }

    { name:     "PAD_ATTRIBUTE_UART_RX",
      desc:     "uart_rx Attributes (Pull Up En, Pull Down En, etc. It is technology specific.",
      resval:   "0x00"
      swaccess: "rw",
      hwaccess: "hro",
      fields: [
        { bits: "7:0", name: "PAD_ATTRIBUTE_UART_RX", desc: "Pad Attribute UART_RX Reg" }
      ]
    }

    { name:     "PAD_ATTRIBUTE_UART_TX",
      desc:     "uart_tx Attributes (Pull Up En, Pull Down En, etc. It is technology specific.",
      resval:   "0x00"
      swaccess: "rw",
      hwaccess: "hro",
      fields: [
        { bits: "7:0", name: "PAD_ATTRIBUTE_UART_TX", desc: "Pad Attribute UART_TX Reg" }
      ]
    }

    { name:     "PAD_ATTRIBUTE_EXIT_VALID",
      desc:     "exit_valid Attributes (Pull Up En, Pull Down En, etc. It is technology specific.",
      resval:   "0x00"
      swaccess: "rw",
      hwaccess: "hro",
      fields: [
        { bits: "7:0", name: "PAD_ATTRIBUTE_EXIT_VALID", desc: "Pad Attribute EXIT_VALID Reg" }
      ]
    }

    { name:     "PAD_ATTRIBUTE_GPIO_0",
      desc:     "gpio_0 Attributes (Pull Up En, Pull Down En, etc. It is technology specific.",
      resval:   "0x00"
      swaccess: "rw",
      hwaccess: "hro",
      fields: [
        { bits: "7:0", name: "PAD_ATTRIBUTE_GPIO_0", desc: "Pad Attribute GPIO_0 Reg" }
      ]
    }

    { name:     "PAD_ATTRIBUTE_GPIO_1",
      desc:     "gpio_1 Attributes (Pull Up En, Pull Down En, etc. It is technology specific.",
      resval:   "0x00"
      swaccess: "rw",
      hwaccess: "hro",
      fields: [
        { bits: "7:0", name: "PAD_ATTRIBUTE_GPIO_1", desc: "Pad Attribute GPIO_1 Reg" }
      ]
    }

    { name:     "PAD_ATTRIBUTE_GPIO_2",
      desc:     "gpio_2 Attributes (Pull Up En, Pull Down En, etc. It is technology specific.",
      resval:   "0x00"
      swaccess: "rw",
      hwaccess: "hro",
      fields: [
        { bits: "7:0", name: "PAD_ATTRIBUTE_GPIO_2", desc: "Pad Attribute GPIO_2 Reg" }
      ]
    }

    { name:     "PAD_ATTRIBUTE_GPIO_3",
      desc:     "gpio_3 Attributes (Pull Up En, Pull Down En, etc. It is technology specific.",
      resval:   "0x00"
      swaccess: "rw",
      hwaccess: "hro",
      fields: [
        { bits: "7:0", name: "PAD_ATTRIBUTE_GPIO_3", desc: "Pad Attribute GPIO_3 Reg" }
      ]
    }

    { name:     "PAD_ATTRIBUTE_GPIO_4",
      desc:     "gpio_4 Attributes (Pull Up En, Pull Down En, etc. It is technology specific.",
      resval:   "0x00"
      swaccess: "rw",
      hwaccess: "hro",
      fields: [
        { bits: "7:0", name: "PAD_ATTRIBUTE_GPIO_4", desc: "Pad Attribute GPIO_4 Reg" }
      ]
    }

    { name:     "PAD_ATTRIBUTE_GPIO_5",
      desc:     "gpio_5 Attributes (Pull Up En, Pull Down En, etc. It is technology specific.",
      resval:   "0x00"
      swaccess: "rw",
      hwaccess: "hro",
      fields: [
        { bits: "7:0", name: "PAD_ATTRIBUTE_GPIO_5", desc: "Pad Attribute GPIO_5 Reg" }
      ]
    }

    { name:     "PAD_ATTRIBUTE_GPIO_6",
      desc:     "gpio_6 Attributes (Pull Up En, Pull Down En, etc. It is technology specific.",
      resval:   "0x00"
      swaccess: "rw",
      hwaccess: "hro",
      fields: [
        { bits: "7:0", name: "PAD_ATTRIBUTE_GPIO_6", desc: "Pad Attribute GPIO_6 Reg" }
      ]
    }

    { name:     "PAD_ATTRIBUTE_GPIO_7",
      desc:     "gpio_7 Attributes (Pull Up En, Pull Down En, etc. It is technology specific.",
      resval:   "0x00"
      swaccess: "rw",
      hwaccess: "hro",
      fields: [
        { bits: "7:0", name: "PAD_ATTRIBUTE_GPIO_7", desc: "Pad Attribute GPIO_7 Reg" }
      ]
    }

    { name:     "PAD_ATTRIBUTE_GPIO_8",
      desc:     "gpio_8 Attributes (Pull Up En, Pull Down En, etc. It is technology specific.",
      resval:   "0x00"
      swaccess: "rw",
      hwaccess: "hro",
      fields: [
        { bits: "7:0", name: "PAD_ATTRIBUTE_GPIO_8", desc: "Pad Attribute GPIO_8 Reg" }
      ]
    }

    { name:     "PAD_ATTRIBUTE_GPIO_9",
      desc:     "gpio_9 Attributes (Pull Up En, Pull Down En, etc. It is technology specific.",
      resval:   "0x00"
      swaccess: "rw",
      hwaccess: "hro",
      fields: [
        { bits: "7:0", name: "PAD_ATTRIBUTE_GPIO_9", desc: "Pad Attribute GPIO_9 Reg" }
      ]
    }

    { name:     "PAD_ATTRIBUTE_GPIO_10",
      desc:     "gpio_10 Attributes (Pull Up En, Pull Down En, etc. It is technology specific.",
      resval:   "0x00"
      swaccess: "rw",
      hwaccess: "hro",
      fields: [
        { bits: "7:0", name: "PAD_ATTRIBUTE_GPIO_10", desc: "Pad Attribute GPIO_10 Reg" }
      ]
    }

    { name:     "PAD_ATTRIBUTE_GPIO_11",
      desc:     "gpio_11 Attributes (Pull Up En, Pull Down En, etc. It is technology specific.",
      resval:   "0x00"
      swaccess: "rw",
      hwaccess: "hro",
      fields: [
        { bits: "7:0", name: "PAD_ATTRIBUTE_GPIO_11", desc: "Pad Attribute GPIO_11 Reg" }
      ]
    }

    { name:     "PAD_ATTRIBUTE_GPIO_12",
      desc:     "gpio_12 Attributes (Pull Up En, Pull Down En, etc. It is technology specific.",
      resval:   "0x00"
      swaccess: "rw",
      hwaccess: "hro",
      fields: [
        { bits: "7:0", name: "PAD_ATTRIBUTE_GPIO_12", desc: "Pad Attribute GPIO_12 Reg" }
      ]
    }

    { name:     "PAD_ATTRIBUTE_GPIO_13",
      desc:     "gpio_13 Attributes (Pull Up En, Pull Down En, etc. It is technology specific.",
      resval:   "0x00"
      swaccess: "rw",
      hwaccess: "hro",
      fields: [
        { bits: "7:0", name: "PAD_ATTRIBUTE_GPIO_13", desc: "Pad Attribute GPIO_13 Reg" }
      ]
    }

    { name:     "PAD_ATTRIBUTE_GPIO_14",
      desc:     "gpio_14 Attributes (Pull Up En, Pull Down En, etc. It is technology specific.",
      resval:   "0x00"
      swaccess: "rw",
      hwaccess: "hro",
      fields: [
        { bits: "7:0", name: "PAD_ATTRIBUTE_GPIO_14", desc: "Pad Attribute GPIO_14 Reg" }
      ]
    }

    { name:     "PAD_ATTRIBUTE_GPIO_15",
      desc:     "gpio_15 Attributes (Pull Up En, Pull Down En, etc. It is technology specific.",
      resval:   "0x00"
      swaccess: "rw",
      hwaccess: "hro",
      fields: [
        { bits: "7:0", name: "PAD_ATTRIBUTE_GPIO_15", desc: "Pad Attribute GPIO_15 Reg" }
      ]
    }

    { name:     "PAD_ATTRIBUTE_GPIO_16",
      desc:     "gpio_16 Attributes (Pull Up En, Pull Down En, etc. It is technology specific.",
      resval:   "0x00"
      swaccess: "rw",
      hwaccess: "hro",
      fields: [
        { bits: "7:0", name: "PAD_ATTRIBUTE_GPIO_16", desc: "Pad Attribute GPIO_16 Reg" }
      ]
    }

    { name:     "PAD_ATTRIBUTE_GPIO_17",
      desc:     "gpio_17 Attributes (Pull Up En, Pull Down En, etc. It is technology specific.",
      resval:   "0x00"
      swaccess: "rw",
      hwaccess: "hro",
      fields: [
        { bits: "7:0", name: "PAD_ATTRIBUTE_GPIO_17", desc: "Pad Attribute GPIO_17 Reg" }
      ]
    }

    { name:     "PAD_ATTRIBUTE_GPIO_18",
      desc:     "gpio_18 Attributes (Pull Up En, Pull Down En, etc. It is technology specific.",
      resval:   "0x00"
      swaccess: "rw",
      hwaccess: "hro",
      fields: [
        { bits: "7:0", name: "PAD_ATTRIBUTE_GPIO_18", desc: "Pad Attribute GPIO_18 Reg" }
      ]
    }

    { name:     "PAD_ATTRIBUTE_GPIO_19",
      desc:     "gpio_19 Attributes (Pull Up En, Pull Down En, etc. It is technology specific.",
      resval:   "0x00"
      swaccess: "rw",
      hwaccess: "hro",
      fields: [
        { bits: "7:0", name: "PAD_ATTRIBUTE_GPIO_19", desc: "Pad Attribute GPIO_19 Reg" }
      ]
    }

    { name:     "PAD_ATTRIBUTE_GPIO_20",
      desc:     "gpio_20 Attributes (Pull Up En, Pull Down En, etc. It is technology specific.",
      resval:   "0x00"
      swaccess: "rw",
      hwaccess: "hro",
      fields: [
        { bits: "7:0", name: "PAD_ATTRIBUTE_GPIO_20", desc: "Pad Attribute GPIO_20 Reg" }
      ]
    }

    { name:     "PAD_ATTRIBUTE_GPIO_21",
      desc:     "gpio_21 Attributes (Pull Up En, Pull Down En, etc. It is technology specific.",
      resval:   "0x00"
      swaccess: "rw",
      hwaccess: "hro",
      fields: [
        { bits: "7:0", name: "PAD_ATTRIBUTE_GPIO_21", desc: "Pad Attribute GPIO_21 Reg" }
      ]
    }

    { name:     "PAD_ATTRIBUTE_GPIO_22",
      desc:     "gpio_22 Attributes (Pull Up En, Pull Down En, etc. It is technology specific.",
      resval:   "0x00"
      swaccess: "rw",
      hwaccess: "hro",
      fields: [
        { bits: "7:0", name: "PAD_ATTRIBUTE_GPIO_22", desc: "Pad Attribute GPIO_22 Reg" }
      ]
    }

    { name:     "PAD_ATTRIBUTE_GPIO_23",
      desc:     "gpio_23 Attributes (Pull Up En, Pull Down En, etc. It is technology specific.",
      resval:   "0x00"
      swaccess: "rw",
      hwaccess: "hro",
      fields: [
        { bits: "7:0", name: "PAD_ATTRIBUTE_GPIO_23", desc: "Pad Attribute GPIO_23 Reg" }
      ]
    }

    { name:     "PAD_ATTRIBUTE_GPIO_24",
      desc:     "gpio_24 Attributes (Pull Up En, Pull Down En, etc. It is technology specific.",
      resval:   "0x00"
      swaccess: "rw",
      hwaccess: "hro",
      fields: [
        { bits: "7:0", name: "PAD_ATTRIBUTE_GPIO_24", desc: "Pad Attribute GPIO_24 Reg" }
      ]
    }

    { name:     "PAD_ATTRIBUTE_GPIO_25",
      desc:     "gpio_25 Attributes (Pull Up En, Pull Down En, etc. It is technology specific.",
      resval:   "0x00"
      swaccess: "rw",
      hwaccess: "hro",
      fields: [
        { bits: "7:0", name: "PAD_ATTRIBUTE_GPIO_25", desc: "Pad Attribute GPIO_25 Reg" }
      ]
    }

    { name:     "PAD_ATTRIBUTE_GPIO_26",
      desc:     "gpio_26 Attributes (Pull Up En, Pull Down En, etc. It is technology specific.",
      resval:   "0x00"
      swaccess: "rw",
      hwaccess: "hro",
      fields: [
        { bits: "7:0", name: "PAD_ATTRIBUTE_GPIO_26", desc: "Pad Attribute GPIO_26 Reg" }
      ]
    }

    { name:     "PAD_ATTRIBUTE_GPIO_27",
      desc:     "gpio_27 Attributes (Pull Up En, Pull Down En, etc. It is technology specific.",
      resval:   "0x00"
      swaccess: "rw",
      hwaccess: "hro",
      fields: [
        { bits: "7:0", name: "PAD_ATTRIBUTE_GPIO_27", desc: "Pad Attribute GPIO_27 Reg" }
      ]
    }

    { name:     "PAD_ATTRIBUTE_GPIO_28",
      desc:     "gpio_28 Attributes (Pull Up En, Pull Down En, etc. It is technology specific.",
      resval:   "0x00"
      swaccess: "rw",
      hwaccess: "hro",
      fields: [
        { bits: "7:0", name: "PAD_ATTRIBUTE_GPIO_28", desc: "Pad Attribute GPIO_28 Reg" }
      ]
    }

    { name:     "PAD_ATTRIBUTE_GPIO_29",
      desc:     "gpio_29 Attributes (Pull Up En, Pull Down En, etc. It is technology specific.",
      resval:   "0x00"
      swaccess: "rw",
      hwaccess: "hro",
      fields: [
        { bits: "7:0", name: "PAD_ATTRIBUTE_GPIO_29", desc: "Pad Attribute GPIO_29 Reg" }
      ]
    }

    { name:     "PAD_ATTRIBUTE_GPIO_30",
      desc:     "gpio_30 Attributes (Pull Up En, Pull Down En, etc. It is technology specific.",
      resval:   "0x00"
      swaccess: "rw",
      hwaccess: "hro",
      fields: [
        { bits: "7:0", name: "PAD_ATTRIBUTE_GPIO_30", desc: "Pad Attribute GPIO_30 Reg" }
      ]
    }

    { name:     "PAD_ATTRIBUTE_SPI_FLASH_SCK",
      desc:     "spi_flash_sck Attributes (Pull Up En, Pull Down En, etc. It is technology specific.",
      resval:   "0x00"
      swaccess: "rw",
      hwaccess: "hro",
      fields: [
        { bits: "7:0", name: "PAD_ATTRIBUTE_SPI_FLASH_SCK", desc: "Pad Attribute SPI_FLASH_SCK Reg" }
      ]
    }

    { name:     "PAD_ATTRIBUTE_SPI_FLASH_CS_0",
      desc:     "spi_flash_cs_0 Attributes (Pull Up En, Pull Down En, etc. It is technology specific.",
      resval:   "0x00"
      swaccess: "rw",
      hwaccess: "hro",
      fields: [
        { bits: "7:0", name: "PAD_ATTRIBUTE_SPI_FLASH_CS_0", desc: "Pad Attribute SPI_FLASH_CS_0 Reg" }
      ]
    }

    { name:     "PAD_ATTRIBUTE_SPI_FLASH_CS_1",
      desc:     "spi_flash_cs_1 Attributes (Pull Up En, Pull Down En, etc. It is technology specific.",
      resval:   "0x00"
      swaccess: "rw",
      hwaccess: "hro",
      fields: [
        { bits: "7:0", name: "PAD_ATTRIBUTE_SPI_FLASH_CS_1", desc: "Pad Attribute SPI_FLASH_CS_1 Reg" }
      ]
    }

    { name:     "PAD_ATTRIBUTE_SPI_FLASH_SD_0",
      desc:     "spi_flash_sd_0 Attributes (Pull Up En, Pull Down En, etc. It is technology specific.",
      resval:   "0x00"
      swaccess: "rw",
      hwaccess: "hro",
      fields: [
        { bits: "7:0", name: "PAD_ATTRIBUTE_SPI_FLASH_SD_0", desc: "Pad Attribute SPI_FLASH_SD_0 Reg" }
      ]
    }

    { name:     "PAD_ATTRIBUTE_SPI_FLASH_SD_1",
      desc:     "spi_flash_sd_1 Attributes (Pull Up En, Pull Down En, etc. It is technology specific.",
      resval:   "0x00"
      swaccess: "rw",
      hwaccess: "hro",
      fields: [
        { bits: "7:0", name: "PAD_ATTRIBUTE_SPI_FLASH_SD_1", desc: "Pad Attribute SPI_FLASH_SD_1 Reg" }
      ]
    }

    { name:     "PAD_ATTRIBUTE_SPI_FLASH_SD_2",
      desc:     "spi_flash_sd_2 Attributes (Pull Up En, Pull Down En, etc. It is technology specific.",
      resval:   "0x00"
      swaccess: "rw",
      hwaccess: "hro",
      fields: [
        { bits: "7:0", name: "PAD_ATTRIBUTE_SPI_FLASH_SD_2", desc: "Pad Attribute SPI_FLASH_SD_2 Reg" }
      ]
    }

    { name:     "PAD_ATTRIBUTE_SPI_FLASH_SD_3",
      desc:     "spi_flash_sd_3 Attributes (Pull Up En, Pull Down En, etc. It is technology specific.",
      resval:   "0x00"
      swaccess: "rw",
      hwaccess: "hro",
      fields: [
        { bits: "7:0", name: "PAD_ATTRIBUTE_SPI_FLASH_SD_3", desc: "Pad Attribute SPI_FLASH_SD_3 Reg" }
      ]
    }

    { name:     "PAD_ATTRIBUTE_SPI_SCK",
      desc:     "spi_sck Attributes (Pull Up En, Pull Down En, etc. It is technology specific.",
      resval:   "0x00"
      swaccess: "rw",
      hwaccess: "hro",
      fields: [
        { bits: "7:0", name: "PAD_ATTRIBUTE_SPI_SCK", desc: "Pad Attribute SPI_SCK Reg" }
      ]
    }

    { name:     "PAD_ATTRIBUTE_SPI_CS_0",
      desc:     "spi_cs_0 Attributes (Pull Up En, Pull Down En, etc. It is technology specific.",
      resval:   "0x00"
      swaccess: "rw",
      hwaccess: "hro",
      fields: [
        { bits: "7:0", name: "PAD_ATTRIBUTE_SPI_CS_0", desc: "Pad Attribute SPI_CS_0 Reg" }
      ]
    }

    { name:     "PAD_ATTRIBUTE_SPI_CS_1",
      desc:     "spi_cs_1 Attributes (Pull Up En, Pull Down En, etc. It is technology specific.",
      resval:   "0x00"
      swaccess: "rw",
      hwaccess: "hro",
      fields: [
        { bits: "7:0", name: "PAD_ATTRIBUTE_SPI_CS_1", desc: "Pad Attribute SPI_CS_1 Reg" }
      ]
    }

    { name:     "PAD_ATTRIBUTE_SPI_SD_0",
      desc:     "spi_sd_0 Attributes (Pull Up En, Pull Down En, etc. It is technology specific.",
      resval:   "0x00"
      swaccess: "rw",
      hwaccess: "hro",
      fields: [
        { bits: "7:0", name: "PAD_ATTRIBUTE_SPI_SD_0", desc: "Pad Attribute SPI_SD_0 Reg" }
      ]
    }

    { name:     "PAD_ATTRIBUTE_SPI_SD_1",
      desc:     "spi_sd_1 Attributes (Pull Up En, Pull Down En, etc. It is technology specific.",
      resval:   "0x00"
      swaccess: "rw",
      hwaccess: "hro",
      fields: [
        { bits: "7:0", name: "PAD_ATTRIBUTE_SPI_SD_1", desc: "Pad Attribute SPI_SD_1 Reg" }
      ]
    }

    { name:     "PAD_ATTRIBUTE_SPI_SD_2",
      desc:     "spi_sd_2 Attributes (Pull Up En, Pull Down En, etc. It is technology specific.",
      resval:   "0x00"
      swaccess: "rw",
      hwaccess: "hro",
      fields: [
        { bits: "7:0", name: "PAD_ATTRIBUTE_SPI_SD_2", desc: "Pad Attribute SPI_SD_2 Reg" }
      ]
    }

    { name:     "PAD_ATTRIBUTE_SPI_SD_3",
      desc:     "spi_sd_3 Attributes (Pull Up En, Pull Down En, etc. It is technology specific.",
      resval:   "0x00"
      swaccess: "rw",
      hwaccess: "hro",
      fields: [
        { bits: "7:0", name: "PAD_ATTRIBUTE_SPI_SD_3", desc: "Pad Attribute SPI_SD_3 Reg" }
      ]
    }

    { name:     "PAD_ATTRIBUTE_I2C_SCL",
      desc:     "i2c_scl Attributes (Pull Up En, Pull Down En, etc. It is technology specific.",
      resval:   "0x00"
      swaccess: "rw",
      hwaccess: "hro",
      fields: [
        { bits: "7:0", name: "PAD_ATTRIBUTE_I2C_SCL", desc: "Pad Attribute I2C_SCL Reg" }
      ]
    }

    { name:     "PAD_ATTRIBUTE_I2C_SDA",
      desc:     "i2c_sda Attributes (Pull Up En, Pull Down En, etc. It is technology specific.",
      resval:   "0x00"
      swaccess: "rw",
      hwaccess: "hro",
      fields: [
        { bits: "7:0", name: "PAD_ATTRIBUTE_I2C_SDA", desc: "Pad Attribute I2C_SDA Reg" }
      ]
    }



   ]
}
