// Copyright EPFL contributors.
// Licensed under the Apache License, Version 2.0, see LICENSE for details.
// SPDX-License-Identifier: Apache-2.0
{ name: "memcopy_periph",
  clock_primary: "clk_i",
  bus_interfaces: [
    { protocol: "reg_iface", direction: "device" }
  ],
  regwidth: "32",
  registers: [
    { name:     "PTR_READ",
      desc:     "Read data pointer",
      swaccess: "rw",
      hwaccess: "hro",
      fields: [
        { bits: "31:0", name: "PTR_READ", desc: "Read data pointer" }
      ]
    },
    { name:     "PTR_WRITE",
      desc:     "Write data pointer",
      swaccess: "rw",
      hwaccess: "hro",
      fields: [
        { bits: "31:0", name: "PTR_WRITE", desc: "Write data pointer" }
      ]
    },
    { name:     "CNT_START",
      desc:     "Number of data to copy - Once a value is written, the copy starts",
      swaccess: "rw",
      hwaccess: "hrw",
      fields: [
        { bits: "31:0", name: "CNT_START", desc: "Counter and start" }
      ]
    },
    { name:     "DONE",
      desc:     "Register set to 1 when copy is done",
      swaccess: "ro",
      hwaccess: "hrw",
      resval:   1,
      fields: [
        { bits: "31:0", name: "DONE", desc: "Copy done" }
      ]
    }
   ]
}
