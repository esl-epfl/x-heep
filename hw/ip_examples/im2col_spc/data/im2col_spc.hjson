// Copyright EPFL contributors.
// Licensed under the Apache License, Version 2.0, see LICENSE for details.
// SPDX-License-Identifier: Apache-2.0

{ name: "im2col_spc",
  clock_primary: "clk_i",
  bus_interfaces: [
    { protocol: "reg_iface", direction: "device" }
  ],
  regwidth: "32",
  registers: [
    { name:     "SRC_PTR",
      desc:     "Input data pointer (word aligned)",
      swaccess: "rw",
      hwaccess: "hro",
      fields: [
        { bits: "31:0", name: "PTR_IN", desc: "Input data pointer (word aligned)" }
      ]
    },
    { name:     "DST_PTR",
      desc:     "Output data pointer (word aligned)",
      swaccess: "rw",
      hwaccess: "hro",
      fields: [
        { bits: "31:0", name: "PTR_OUT", desc: "Output data pointer (word aligned)" }
      ]
    },
    { name:     "IW",
      desc:     "Image width",
      swaccess: "rw",
      hwaccess: "hro",
      fields: [
        { bits: "31:0", name: "SIZE", desc: "Image width" }
      ]
    },
    { name:     "IH",
      desc:     "Image heigth",
      swaccess: "rw",
      hwaccess: "hro",
      fields: [
        { bits: "31:0", name: "SIZE", desc: "Image heigth" }
      ]
    },
    { name:     "FW",
      desc:     "Filter width",
      swaccess: "rw",
      hwaccess: "hro",
      fields: [
        { bits: "31:0", name: "SIZE", desc: "Filter width" }
      ]
    },
    { name:     "FH",
      desc:     "Filter heigth",
      swaccess: "rw",
      hwaccess: "hro",
      fields: [
        { bits: "31:0", name: "SIZE", desc: "Filter heigth" }
      ]
    },
    { name:     "NUM_CH",
      desc:     "Number of channels",
      swaccess: "rw",
      hwaccess: "hro",
      fields: [
        { bits: "31:0", name: "SIZE", desc: "Filter heigth" }
      ]
    },
    { name:     "STRIDE_D1",
      desc:     "Strides along D1, set to 1 for no stride",
      swaccess: "rw",
      hwaccess: "hro",
      fields: [
        { bits: "31:0", name: "SIZE", desc: "Stride size" }
      ]
    },
    { name:     "STRIDE_D2",
      desc:     "Strides along D2, set to 1 for no stride",
      swaccess: "rw",
      hwaccess: "hro",
      fields: [
        { bits: "31:0", name: "SIZE", desc: "Stride size" }
      ]
    },
    
    { name:     "STATUS",
      desc:     '''Status bits are set to one if a given event occurred''',
      swaccess: "ro",
      hwaccess: "hrw",
      hwext: "true",
      hwre:     "true", // enable `re` latched signal of software read pulse
      resval:   1,
      fields: [
        { bits: "0", name: "READY", desc: "Transaction is done"},
        { bits: "1", name: "WINDOW_DONE", desc: "set if DMA is copying second half"},
      ]
    },
    { name:     "SRC_PTR_INC_D1",
      desc:     "Increment the D1 source pointer every time a word is copied",
      swaccess: "rw",
      hwaccess: "hro",
      // Dimensioned to allow a maximum of a 15 element stride for a data_type_word case
      fields: [
        { bits: "5:0", 
          name: "INC", 
          desc: "Source pointer d1 increment",
          resval:4
        }
      ]
    },
    { name:     "SRC_PTR_INC_D2",
      desc:     "Increment the D2 source pointer every time a word is copied",
      swaccess: "rw",
      hwaccess: "hro",
      // Dimensioned to allow a maximum of 15 element stride for a data_type_word
      fields: [
        { bits: "22:0", 
          name: "INC", 
          desc: "Source pointer d2 increment",
          resval:4
        }
      ]
    },
    { name:     "DST_PTR_INC_D1",
      desc:     "Increment the D1 destination pointer every time a word is copied",
      swaccess: "rw",
      hwaccess: "hro",
      fields: [
        { bits: "5:0", 
          name: "INC", 
          desc: "Destination pointer d1 increment",
          resval:4
        }
      ]
    },
    { name:     "DST_PTR_INC_D2",
      desc:     "Increment the D2 destination pointer every time a word is copied",
      swaccess: "rw",
      hwaccess: "hro",
      fields: [
        { bits: "22:0", 
          name: "INC", 
          desc: "Destination pointer d2 increment",
          resval:4
        }
      ]
    },
    { name:     "SLOT",
      desc:     '''The DMA will wait for the signal 
                   connected to the selected trigger_slots to be high
                   on the read and write side respectivly''',
      swaccess: "rw",
      hwaccess: "hro",
      resval:   0,
      fields: [
        { bits: "15:0", name: "RX_TRIGGER_SLOT",
          desc: "Slot selection mask"
        },
        { bits: "31:16", name: "TX_TRIGGER_SLOT",
          desc: "Slot selection mask"
        }
      ]
    },
    { name:     "DATA_TYPE",
      desc:     '''Width/type of the data to transfer''',
      swaccess: "rw",
      hwaccess: "hro",
      resval:   0,
      fields: [
        { bits: "1:0", name: "DATA_TYPE", 
          desc: "Data type",
          enum: [
            { value: "0", name: "DMA_32BIT_WORD", desc: "Transfers 32 bits"},
            { value: "1", name: "DMA_16BIT_WORD", desc: "Transfers 16 bits"},
            { value: "2", name: "DMA_8BIT_WORD" , desc: "Transfers  8 bits"},
            { value: "3", name: "DMA_8BIT_WORD_2",desc: "Transfers  8 bits"},
          ]
        }
      ]
    },
    { name:     "PAD_TOP",
      desc:     '''Set the top padding''',
      swaccess: "rw",
      hwaccess: "hro",
      hwqe:     "true", // enable `qe` latched signal of software write pulse: used to trigger the padding
      resval:   0,
      fields: [
        { bits: "5:0", name: "PAD", desc: "Top margin padding (2D)"}
      ]
    },
    { name:     "PAD_BOTTOM",
      desc:     '''Set the bottom padding''',
      swaccess: "rw",
      hwaccess: "hro",
      hwqe:     "true", // enable `qe` latched signal of software write pulse: used to trigger the padding
      resval:   0,
      fields: [
        { bits: "5:0", name: "PAD", desc: "Bottom margin padding (2D)"}
      ]
    },
    { name:     "PAD_RIGHT",
      desc:     '''Set the right padding''',
      swaccess: "rw",
      hwaccess: "hro",
      hwqe:     "true", // enable `qe` latched signal of software write pulse: used to trigger the padding
      resval:   0,
      fields: [
        { bits: "5:0", name: "PAD", desc: "Right margin padding (1D/2D)"}
      ]
    },
    { name:     "PAD_LEFT",
      desc:     '''Set the left padding''',
      swaccess: "rw",
      hwaccess: "hro",
      hwqe:     "true", // enable `qe` latched signal of software write pulse: used to trigger the padding
      resval:   0,
      fields: [
        { bits: "5:0", name: "PAD", desc: "Left margin padding (1D/2D)"}
      ]
    },
    { name:    "INTERRUPT_EN",
      desc:    '''Interrupt Enable Register 
                  (Only the interrupt with the lowest id will be triggered)''',
      swaccess: "rw",
      hwaccess: "hro",
      fields: [
        { bits: "0", name: "TRANSACTION_DONE", desc: "Enables transaction done interrupt" }
        { bits: "1", name: "WINDOW_DONE", desc: "Enables window done interrupt" }
      ]
    },
    { name:    "TRANSACTION_IFR",
      desc:    '''Interrupt Flag Register for transaction''',
      swaccess: "ro",
      hwaccess: "hrw",
      hwext:    "true",
      hwre:     "true", // latched signal of software write pulse
      resval:        0,
      fields: [
        { bits: "0", name: "FLAG", desc: "Set for transaction done interrupt" }
      ]
    }
   ]
}
