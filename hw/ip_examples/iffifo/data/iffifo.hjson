// Copyright EPFL contributors.
// Licensed under the Apache License, Version 2.0, see LICENSE for details.
// SPDX-License-Identifier: Apache-2.0

{ name: "iffifo",
  clock_primary: "clk_i",
  bus_interfaces: [
    { protocol: "reg_iface", direction: "device" }
  ],
  regwidth: "32",
  registers: [
    { name:     "DUMMYR",
      desc:     "Does nothing.",
      swaccess: "rw",
      hwaccess: "hro",
      fields: [
        { bits: "31:0", name: "DUMMY", desc: "Does nothing." }
      ]
    },
    { name:     "DUMMYW",
      desc:     "Does nothing.",
      swaccess: "ro",
      hwaccess: "hrw",
      fields: [
        { bits: "31:0", name: "DUMMY", desc: "Does nothing." }
      ]
    },
    { window: {
        name: "FIFO_OUT",
        items: "1",
        validbits: "32",
        desc: '''Data coming from the FIFO (Fifo Output/Software RX)
                  '''
        swaccess: "ro"
      }
    }
    { window: {
        name: "FIFO_IN",
        items: "1",
        validbits: "32",
        desc: '''Data sent to the FIFO (Fifo Input/Software TX)
                  '''
        swaccess: "wo"
      }
    }
  ]
}

