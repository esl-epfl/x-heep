// Copyright EPFL and Politecnico di Torino contributors.
// Licensed under the Apache License, Version 2.0, see LICENSE for details.
// SPDX-License-Identifier: Apache-2.0

{ name: "dlc"
  clock_primary: "clk_i"
  bus_interfaces: [
    { protocol: "reg_iface", direction: "device" }
  ]
  regwidth: "32"
  registers: [
    { name:     "DLVL_LOG_LEVEL_WIDTH"
      desc:     "Log2 of the level width"
      swaccess: "rw"
      hwaccess: "hro"
      fields: [
        { bits: "3:0", name: "LOG_WL", desc: "log2 of the level width" },
      ]
    }
    { name:     "DLVL_N_BITS"
      desc:     "Delta level N bits"
      swaccess: "rw"
      hwaccess: "hro"
      fields: [
        { bits: "3:0", name: "N_BITS", desc: "number of bits allocated to delta levels within the dlc output packet" },
      ]
    }
    { name:     "DLVL_MASK"
      desc:     "Delta level mask"
      swaccess: "rw"
      hwaccess: "hro"
      fields: [
        { bits: "15:0", name: "MASK", desc: "delta level mask, it has many 1s as the number of bits allocated to delta levels within the dlc output packet" },
      ]
    }
    { name:     "DLVL_FORMAT"
      desc:     "Delta level format"
      swaccess: "rw"
      hwaccess: "hro"
      fields: [
        { bits: "0", name: "TWOSCOMP_N_SGNMOD", desc: "if '1' delta levels are in 2s complement, else sign|abs_value" },
      ]
    }
    { name:     "DT_MASK"
      desc:     "Delta time mask"
      swaccess: "rw"
      hwaccess: "hro"
      fields: [
        { bits: "15:0", name: "MASK", desc: "delta time mask, it has many 1s as the number of bits allocated to delta time within the dlc output packet" },
      ]
    }
    { name:     "READNOTWRITE"
      desc:     "dLC response push setting"
      swaccess: "rw",
      hwaccess: "hro",
      fields: [
        { bits: "0", name: "RNW", desc: "if 1, dlc sets response push every time it reads from read_hw_fifo, if 0, dlc set response push every time it pushes to write_hw_fifo" },
      ]
    }
    { name:     "BYPASS"
      desc:     "Bypass input data to output without filter"
      swaccess: "rw"
      hwaccess: "hro"
      fields: [
        { bits: "0", name: "BP", desc: "if 1, dlc forwards input to output" },
      ]
    }
    { name:     "INTERRUPT_EN"
      desc:     "Interrupt enable to be used in bypass mode"
      swaccess: "rw"
      hwaccess: "hro"
      fields: [
        { bits: "0", name: "EN", desc: "if 1, interrupt generation is enable" },
      ]
    }
    { name:     "XING_INTR"
      desc:     "Interrupt bit set whena crossing is detected"
      swaccess: "ro",
      hwaccess: "hrw",
      hwext:    "true",
      hwre:     "true", // latched signal of software write pulse
      fields: [
        { bits: "0", name: "XING", desc: "if 1, interrupt has been triggered" },
      ]
    }
  ]
}
