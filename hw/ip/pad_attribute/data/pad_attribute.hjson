// Copyright lowRISC contributors.
// Licensed under the Apache License, Version 2.0, see LICENSE for details.
// SPDX-License-Identifier: Apache-2.0
{ name: "pad_attribute",
  clock_primary: "clk_i",
  bus_interfaces: [
    { protocol: "reg_iface", direction: "device" }
  ],
  regwidth: "16",
  registers: [
    { name:     "ATTRIBUTE",
      desc:     "Pad Attributes (Pull Up En, Pull Down En, etc. It is technology specific",
      swaccess: "rw",
      hwaccess: "hro",
      fields: [
        { bits: "15:0", name: "ATTRIBUTE", desc: "Pad Attribute Reg" }
      ]
    }
   ]
}
