// Copyright lowRISC contributors.
// Licensed under the Apache License, Version 2.0, see LICENSE for details.
// SPDX-License-Identifier: Apache-2.0
{ name: "obi_spimemio",
  clock_primary: "clk_i",
  bus_interfaces: [
    { protocol: "reg_iface", direction: "device" }
  ],
  regwidth: "32",
  registers: [
    { name:     "START_SPIMEM",
      desc:     "Start SPIMEM",
      swaccess: "rw",
      hwaccess: "hro",
      fields: [
        { bits: "0", name: "START_SPIMEM", desc: "Start YosysHQ SPIMEM Reg" }
      ]
    }
    { name:     "CFG_SPIMEM",
      desc:     "Cfg SPIMEM",
      //none as we use it only to generate the SW
      swaccess: "none",
      hwaccess: "none",
      fields: [
        { bits: "31:0", name: "CFG_SPIMEM", desc: "Cfg YosysHQ SPIMEM Reg" }
      ]
    }
   ]
}
