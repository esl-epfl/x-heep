// Copyright EPFL and Politecnico di Torino contributors.
// Licensed under the Apache License, Version 2.0, see LICENSE for details.
// SPDX-License-Identifier: Apache-2.0

{ name: "my_ip"
  clock_primary: "clk_i"
  bus_interfaces: [
    { protocol: "reg_iface", direction: "device" }
  ]
  regwidth: "32"
  registers: [
    { name:     "CONTROL"
      desc:     "Controls for SPI_FLASH W/R"
      swaccess: "rw"
      hwaccess: "hrw"
      fields: [
        {
          bits: "1",
          name: "WRITE",
          desc: "Write enable",
          resval: "0x0"
        }
        { bits: "0", 
          name: "START", 
          desc: "Start action",
          resval: "0x0"
        }
      ]
    }
    { name:     "ADDRESS"
      desc:     "Address to W/R"
      swaccess: "rw"
      hwaccess: "hrw"
      fields: [
        { bits: "31:0", name: "ADDRESS", desc: "Address to W/R" },
      ]
    }
    { name:     "DATA"
      desc:     "Data to W"
      swaccess: "rw"
      hwaccess: "hrw"
      fields: [
        { bits: "31:0", name: "DATA", desc: "Data to W" },
      ]
    }
    { name:     "LENGTH"
      desc:     "Length of data to W/R"
      swaccess: "rw"
      hwaccess: "hrw"
      fields: [
        { bits: "31:0", name: "LENGTH", desc: "Length of data to W/R" },
      ]
    }
  ]
  interrupt_list: [
    { name: "my_ip_event"
      desc: '''Event-related interrupts.'''
    }
  ]
}
