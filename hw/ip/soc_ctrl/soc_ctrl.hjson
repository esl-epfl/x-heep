// Copyright lowRISC contributors.
// Licensed under the Apache License, Version 2.0, see LICENSE for details.
// SPDX-License-Identifier: Apache-2.0
{ name: "soc_ctrl",
  clock_primary: "clk_i",
  bus_interfaces: [
    { protocol: "reg_iface", direction: "device" }
  ],
  regwidth: "32",
  registers: [
    { name: "SCRATCH_REG",
      desc: "Scratch Register - Used by testbench to check if tests passed",
      swaccess: "rw",
      hwaccess: "hro",
      fields: [
          { bits: "31:0", name: "SCRATCH", desc: "Scratch Reg" }
      ]
    },
    { name:     "EXIT_VALID",
      desc:     "Exit Valid - Used to write exit valid bit",
      swaccess: "rw",
      hwaccess: "hro",
      fields: [
        { bits: "0", name: "EXIT_VALID", desc: "Exit Valid Reg" }
      ]
    },
    { name:     "EXIT_VALUE",
      desc:     "Exit Value - Used to write exit value register",
      swaccess: "rw",
      hwaccess: "hro",
      fields: [
        { bits: "31:0", name: "EXIT_VALUE", desc: "Exit Value Reg" }
      ]
    }
   ]
}
