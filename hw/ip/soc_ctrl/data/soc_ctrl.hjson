// Copyright lowRISC contributors.
// Licensed under the Apache License, Version 2.0, see LICENSE for details.
// SPDX-License-Identifier: Apache-2.0
{ name: "soc_ctrl",
  clock_primary: "clk_i",
  bus_interfaces: [
    { protocol: "reg_iface", direction: "device" }
  ],
  regwidth: "32",
  registers: [
    { name:     "EXIT_VALID",
      desc:     "Exit Valid - Used to write exit valid bit",
      swaccess: "rw",
      hwaccess: "hro",
      fields: [
        { bits: "0", name: "EXIT_VALID", desc: "Exit Valid Reg" }
      ]
    },
    { name:     "EXIT_VALUE",
      desc:     "Exit Value - Used to write exit value register",
      swaccess: "rw",
      hwaccess: "hro",
      fields: [
        { bits: "31:0", name: "EXIT_VALUE", desc: "Exit Value Reg" }
      ]
    }
    { name:     "BOOT_SELECT",
      desc:     "Boot Select Value - Used to decide whether to boot from JTAG or FLASH",
      swaccess: "ro",
      hwaccess: "hrw",
      fields: [
        { bits: "0", name: "BOOT_SELECT", desc: "Boot Select Reg" }
      ]
    }
   ]
}
