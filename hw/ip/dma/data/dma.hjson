// Copyright EPFL contributors.
// Licensed under the Apache License, Version 2.0, see LICENSE for details.
// SPDX-License-Identifier: Apache-2.0

{ name: "dma",
  clock_primary: "clk_i",
  bus_interfaces: [
    { protocol: "reg_iface", direction: "device" }
  ],
  regwidth: "32",
  registers: [
    { name:     "SRC_PTR",
      desc:     "Input data pointer (word aligned)",
      swaccess: "rw",
      hwaccess: "hro",
      fields: [
        { bits: "31:0", name: "PTR_IN", desc: "Input data pointer (word aligned)" }
      ]
    },
    { name:     "DST_PTR",
      desc:     "Output data pointer (word aligned)",
      swaccess: "rw",
      hwaccess: "hro",
      fields: [
        { bits: "31:0", name: "PTR_OUT", desc: "Output data pointer (word aligned)" }
      ]
    },
    { name:     "ADDR_PTR",
      desc:     "Addess data pointer (word aligned)",
      swaccess: "rw",
      hwaccess: "hro",
      fields: [
        { bits: "31:0", name: "PTR_ADDR", desc: "Address data pointer (word aligned) - used only in Address mode" }
      ]
    },
    { name:     "SIZE",
      desc:     "Number of bytes to copy - Once a value is written, the copy starts",
      swaccess: "rw",
      hwaccess: "hro",
      hwqe:     "true", // enable `qe` latched signal of software write pulse
      fields: [
        { bits: "31:0", name: "SIZE", desc: "DMA counter and start" }
      ]
    },
    { name:     "STATUS",
      desc:     '''Status bits are set to one if a given event occurred''',
      swaccess: "ro",
      hwaccess: "hrw",
      hwext: "true",
      hwre:     "true", // enable `re` latched signal of software read pulse
      resval:   1,
      fields: [
        { bits: "0", name: "READY", desc: "Transaction iss done"},
        { bits: "1", name: "WINDOW_DONE", desc: "set if DMA is copying second half"},
      ]
    },
    { name:     "PTR_INC",
      desc:     "Increment number of src/dst pointer every time a word is copied",
      swaccess: "rw",
      hwaccess: "hro",
      fields: [
        { bits: "7:0", 
          name: "SRC_PTR_INC", 
          desc: "Source pointer increment",
          resval:4
        },
        { bits: "15:8", 
          name: "DST_PTR_INC", 
          desc: "Destination pointer increment",
          resval:4
        }
      ]
    },
    { name:     "SLOT",
      desc:     '''The DMA will wait for the signal 
                   connected to the selected trigger_slots to be high
                   on the read and write side respectivly''',
      swaccess: "rw",
      hwaccess: "hro",
      resval:   0,
      fields: [
        { bits: "15:0", name: "RX_TRIGGER_SLOT",
          desc: "Slot selection mask"
        },
        { bits: "31:16", name: "TX_TRIGGER_SLOT",
          desc: "Slot selection mask"
        }
      ]
    },
    { name:     "DATA_TYPE",
      desc:     '''Width/type of the data to transfer''',
      swaccess: "rw",
      hwaccess: "hro",
      resval:   0,
      fields: [
        { bits: "1:0", name: "DATA_TYPE", 
          desc: "Data type",
          enum: [
            { value: "0", name: "DMA_32BIT_WORD", desc: "Transfers 32 bits"},
            { value: "1", name: "DMA_16BIT_WORD", desc: "Transfers 16 bits"},
            { value: "2", name: "DMA_8BIT_WORD" , desc: "Transfers  8 bits"},
            { value: "3", name: "DMA_8BIT_WORD_2",desc: "Transfers  8 bits"},
          ]
        }
      ]
    },
    { name:     "MODE",
      desc:     '''Set the operational mode of the DMA''',
      swaccess: "rw",
      hwaccess: "hro",
      fields: [
        { bits: "1:0", name: "MODE",
          desc: "DMA operation mode",
          enum: [
            { value: "0", name: "LINEAR_MODE", desc: "Transfers data linearly"},
            { value: "1", name: "CIRCULAR_MODE", desc: "Transfers data in circular mode"},
            { value: "2", name: "ADDRESS_MODE" , desc: "Transfers data using as destination address the data from ADD_PTR"},
          ]
        }
      ]
    },
    { name:    "WINDOW_SIZE",
      desc:    '''Will trigger a every "WINDOW_SIZE" writes
                  Set to 0 to disable.''',
      swaccess: "rw",
      hwaccess: "hro",
      fields: [
        { bits: "31:0", name: "WINDOW_SIZE", desc: ""}
      ]
    },
    { name:    "WINDOW_COUNT",
      desc:    '''Number of times the end of the window was reached since the beginning.
                  Reset at start''',
      swaccess: "ro",
      // hwext: "true",
      hwaccess: "hrw",
      resval: 0,
      fields: [
        { bits: "31:0", name: "WINDOW_COUNT", desc: "Number of windows transferred in the transaction" }
      ]
    },
    { name:    "INTERRUPT_EN",
      desc:    '''Interrupt Enable Register 
                  (Only the interrupt with the lowest id will be triggered)''',
      swaccess: "rw",
      hwaccess: "hro",
      fields: [
        { bits: "0", name: "TRANSACTION_DONE", desc: "Enables transaction done interrupt" }
        { bits: "1", name: "WINDOW_DONE", desc: "Enables window done interrupt" }
      ]
    }
   ]
}
