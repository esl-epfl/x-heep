// Copyright EPFL contributors.
// Licensed under the Apache License, Version 2.0, see LICENSE for details.
// SPDX-License-Identifier: Apache-2.0

{ name: "dma",
  clock_primary: "clk_i",
  bus_interfaces: [
    { protocol: "reg_iface", direction: "device" }
  ],
  regwidth: "32",
  registers: [
    { name:     "PTR_IN",
      desc:     "Input data pointer (word aligned)",
      swaccess: "rw",
      hwaccess: "hro",
      fields: [
        { bits: "31:0", name: "PTR_IN", desc: "Input data pointer (word aligned)" }
      ]
    },
    { name:     "PTR_OUT",
      desc:     "Output data pointer (word aligned)",
      swaccess: "rw",
      hwaccess: "hro",
      fields: [
        { bits: "31:0", name: "PTR_OUT", desc: "Output data pointer (word aligned)" }
      ]
    },
    { name:     "DMA_START",
      desc:     "Number of words (4 bytes) to copy - Once a value is written, the copy starts",
      swaccess: "rw",
      hwaccess: "hrw",
      fields: [
        { bits: "31:0", name: "DMA_START", desc: "DMA counter and start" }
      ]
    },
    { name:     "DONE",
      desc:     "Register set to 1 when copy is done",
      swaccess: "ro",
      hwaccess: "hrw",
      resval:   1,
      fields: [
        { bits: "31:0", name: "DONE", desc: "Copy done" }
      ]
    },
    { name:     "SRC_PTR_INC",
      desc:     "Increment number of source pointer every time a word is copied from source",
      swaccess: "rw",
      hwaccess: "hro",
      resval:   4,
      fields: [
        { bits: "31:0", name: "SRC_PTR_INC", desc: "Source pointer increment" }
      ]
    },
    { name:     "DST_PTR_INC",
      desc:     "Increment number of source pointer every time a word is copied to destination",
      swaccess: "rw",
      hwaccess: "hro",
      resval:   4,
      fields: [
        { bits: "31:0", name: "DST_PTR_INC", desc: "Destination pointer increment" }
      ]
    },
    { name:     "SPI_MODE",
      desc:     "Register set to 1 when copy from SPI, it waits for the spi watermark to start the transaction",
      swaccess: "rw",
      hwaccess: "hro",
      resval:   0,
      fields: [
        { bits: "0", name: "SPI_MODE", desc: "Copy from SPI" }
      ]
    }
   ]
}
