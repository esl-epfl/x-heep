// Copyright EPFL contributors.
// Licensed under the Apache License, Version 2.0, see LICENSE for details.
// SPDX-License-Identifier: Apache-2.0

{ name: "i2s",
  clock_primary: "clk_i",
  bus_interfaces: [
    { protocol: "reg_iface", direction: "device" }
  ],
  regwidth: "32",
  param_list: [
    { name: "BytePerSampleWidth",
      desc: '''Defines the maximal number of bytes that can be 
               configured to be received per sample''',
      type: "int",
      default: "2"
    }
    { name: "ClkDivSize",
      desc: '''Bits available for the clock divider''',
      type: "int",
      default: "16"
    }
  ]
  interrupt_list: [
    { name: "i2s_event",
      desc: '''Event-related interrupts, see !!EVENT_ENABLE register for more
               information.'''
    }
  ],
  no_auto_intr_regs: "true",
  registers: [

    // CLOCK DIVISION

    { name:     "CLKDIVIDX"
      desc:     "Control register"
      swaccess: "rw"
      hwaccess: "hro"
      fields: [
        { bits: "15:0", name: "COUNT", desc: "Index at which clock divide." }
      ]
    }

    // STATUS & CONTROL REGISTERS

    { name:     "cfg"
      desc:     "config register"
      swaccess: "rw"
      hwaccess: "hro"
      fields: [
        { bits: "1:0", name: "EN", desc: "Enable i2s channels" 
          resval: "0",
          enum:  [
            { value: "0", name: "DISABLED",  desc: "Disable I2s" },
            { value: "1", name: "ONLY_LEFT",  desc: "Enable left channel" },
            { value: "2", name: "ONLY_RIGHT",  desc: "Enable right channel" },
            { value: "3", name: "BOTH_CHANNELS",  desc: "Enable both channels" },
          ]
        }
        { bits: "2", name: "LSB_FIRST", desc: "which bit arrives first" }
        { bits: "3", name: "INTR_EN", desc: "enable reach count interrupt" }
        { bits: "5:4", name: "DATA_WIDTH",
          desc: "Bytes per sample",
          resval: "3",
          enum: [
                { value: "0", name: "8_BITS",  desc: "8 bits" },
                { value: "1", name: "16_BITS", desc: "16 bits" },
                { value: "2", name: "24_BITS", desc: "24 bits" },
                { value: "3", name: "32_BITS", desc: "32 bits" }
              ]
        }
        { bits: "6", name: "GEN_CLK_WS", desc: "Generate SCK and WS" }
      ]
    }

    { name:     "Watermark"
      desc:     "Watermark to reach for an interrupt"
      swaccess: "rw"
      hwaccess: "hro"
      fields: [
        { bits: "31:0", name: "Watermark", desc: "Count of RX samples written to memory which should trigger an interrupt"}
      ]
    }

    { window: {
        name: "RXDATA",
        items: "1",
        validbits: "32",
        desc: "I2s Receive data"
        swaccess: "ro"
      }
    }
   ]
}
