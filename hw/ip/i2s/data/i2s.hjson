// Copyright EPFL contributors.
// Licensed under the Apache License, Version 2.0, see LICENSE for details.
// SPDX-License-Identifier: Apache-2.0

{ name: "i2s",
  clock_primary: "clk_i",
  bus_interfaces: [
    { protocol: "reg_iface", direction: "device" }
  ],
  regwidth: "32",
  registers: [

    // CLOCK DIVISION

    // { name:     "CLKDIVIDX"
    //   desc:     "Control register"
    //   swaccess: "rw"
    //   hwaccess: "hro"
    //   fields: [
    //     { bits: "15:0", name: "COUNT", desc: "Index at which clock divide." }
    //   ]
    // }

    // { name:     "CLKSRC"
    //   desc:     "Clk source"
    //   swaccess: "rw"
    //   hwaccess: "hro"
    //   fields: [
    //     { bits: "15:0", name: "COUNT", desc: "Index at which clock divide." }
    //   ]
    // }

    // STATUS & CONTROL REGISTERS

    // { name:     "CONTROL"
    //   desc:     "Control register"
    //   swaccess: "rw"
    //   hwaccess: "hro"
    //   fields: [
    //     { bits: "0", name: "ENABL", desc: "Starts PDM data processing. The FIFO starts to fill with PCM data." }
    //     { bits: "1", name: "CLEAR", desc: "Clears the FIFO buffer." }
    //   ]
    // }

    // { name:     "STATUS"
    //   desc:     "Status register"
    //   swaccess: "ro"
    //   hwaccess: "hrw"
    //   fields: [
    //     { bits: "0", name: "EMPTY", desc: "The FIFO buffer is empty." }
    //     { bits: "1", name: "REACH", desc: "The FIFO buffer reached the specified quantity of signal taps." }
    //     { bits: "2", name: "FULLL", desc: "The FIFO buffer is full."}
    //   ]
    // }

    { name:     "OUTPUTDATA"
      desc:     "Status register"
      swaccess: "ro"
      hwaccess: "hrw"
      fields: [
        { bits: "31:0", name: "OUTPUTDATA", desc:     "Status register"}
      ]
    }

    { name:     "INPUTDATA"
      desc:     "Status register"
      swaccess: "rw"
      hwaccess: "hro"
      hwqe: "true"
      fields: [
        { bits: "31:0", name: "OUTPUTDATA", desc:     "Status register"}
     ]
    }

    { window: {
        name: "RXDATA",
        items: "1",
        validbits: "32",
        desc: "I2s Receive data"
        swaccess: "ro"
      }
    }
   ]
}
