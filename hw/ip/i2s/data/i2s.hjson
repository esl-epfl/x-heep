// Copyright EPFL contributors.
// Licensed under the Apache License, Version 2.0, see LICENSE for details.
// SPDX-License-Identifier: Apache-2.0

{ name: "i2s",
  clock_primary: "clk_i",
  bus_interfaces: [
    { protocol: "reg_iface", direction: "device" }
  ],
  regwidth: "32",
  param_list: [
    { name: "BytePerSampleWidth",
      desc: '''Defines the maximal number of bytes that can be 
               configured to be received per sample''',
      type: "int",
      default: "2"
    }
    { name: "ClkDivSize",
      desc: '''Bits available for the clock divider''',
      type: "int",
      default: "16"
    }
  ]
  registers: [

    // CLOCK DIVISION

    { name:     "CLKDIVIDX"
      desc:     "Control register"
      swaccess: "rw"
      hwaccess: "hro"
      fields: [
        { bits: "15:0", name: "COUNT", desc: "Index at which clock divide." }
      ]
    }

    { name:     "BYTEPERSAMPLE"
      desc:     "Byte per sample"
      swaccess: "rw"
      hwaccess: "hro"
      fields: [
        { bits: "1:0", name: "COUNT",
        desc: "Index at which clock divide.",
        resval: "3",
        enum: [
                { value: "0", name: "8_BITS",  desc: "8 bits" },
                { value: "1", name: "16_BITS", desc: "16 bits" },
                { value: "2", name: "24_BITS", desc: "24 bits" },
                { value: "3", name: "32_BITS", desc: "32 bits" }
              ]
        }
      ]
    }

    // STATUS & CONTROL REGISTERS

    { name:     "cfg"
      desc:     "config register"
      swaccess: "rw"
      hwaccess: "hro"
      fields: [
        { bits: "0", name: "EN", desc: "Starts PDM data processing. The FIFO starts to fill with PCM data." }
        { bits: "1", name: "GEN_CLK_WS", desc: "Generate SCK and WS" }
        { bits: "2", name: "LSB_FIRST", desc: "which bit arrives first" }
        { bits: "23:16", name: "REACHCOUNT", desc: "FIFO count to reach to show at status"}
      ]
    }

  

    { name:     "control"
      desc:     "control register"
      swaccess: "rw"
      hwaccess: "hrw"
      fields: [
        // { bits: "0", name: "CLEAR_FIFO", desc: "Clears the FIFO buffer." }
        { bits: "1", name: "CLEAR_OVERFLOW", desc: "Clears the FIFO buffer." }
      ]
    }

    { name:     "STATUS"
      desc:     "Status register"
      swaccess: "ro"
      hwaccess: "hrw"
      fields: [
        { bits: "0", name: "EMPTY", desc: "The FIFO buffer is empty." }
        // { bits: "1", name: "FULL",  desc: "The FIFO buffer is full."}
        { bits: "2", name: "OVERFLOW",  desc: "The FIFO buffer is full."}
        // { bits: "15:8", name: "FILL_LEVEL", desc: "The FIFO buffer fill level" }
      ]
    }

    { window: {
        name: "RXDATA",
        items: "1",
        validbits: "32",
        desc: "I2s Receive data"
        swaccess: "ro"
      }
    }
   ]
}
