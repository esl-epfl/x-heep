// Copyright 2022 EPFL
// Solderpad Hardware License, Version 2.1, see LICENSE.md for details.
// SPDX-License-Identifier: Apache-2.0 WITH SHL-2.1

// Author: Pierre Guillod <pierre.guillod@epfl.ch>, EPFL, STI-SEL
// Date: 19.02.2022

{ name: "pdm2pcm"
  clock_primary: "clk_i"
  bus_interfaces: [
    { protocol: "reg_iface", direction: "device" }
  ]
  regwidth: "32"
  registers: [

    // CLOCK DIVISION

    { name:     "CLKDIVIDX"
      desc:     "Control register"
      swaccess: "rw"
      hwaccess: "hro"
      fields: [
        { bits: "15:0", name: "COUNT", desc: "Index at which clock divide." }
      ]
    }

    // STATUS & CONTROL REGISTERS

    { name:     "CONTROL"
      desc:     "Control register"
      swaccess: "rw"
      hwaccess: "hro"
      fields: [
        { bits: "0", name: "ENABL", desc: "Starts PDM data processing. The FIFO starts to fill with PCM data." }
        { bits: "1", name: "CLEAR", desc: "Clears the FIFO buffer." }
      ]
    }

    { name:     "STATUS"
      desc:     "Status register"
      swaccess: "ro"
      hwaccess: "hrw"
      fields: [
        { bits: "0", name: "EMPTY", desc: "The FIFO buffer is empty." }
        { bits: "1", name: "REACH", desc: "The FIFO buffer reached the specified quantity of signal taps." }
        { bits: "2", name: "FULLL", desc: "The FIFO buffer is full."}
      ]
    }

    // WINDOW INTERFACE CONFIGURATION

    { name:     "REACHCOUNT"
      desc:     "Number of signal taps stored into the FIFO to assert the FILLD bit in the STATUS register."
      swaccess: "rw"
      hwaccess: "hro"
      fields: [
        { bits: "5:0", name: "COUNT", desc: "Set the signal taps count" }
      ]
    }

    // DECIMATORS

    { name:     "DECIMCIC"
      desc:     "Samples count after which to decimate in the CIC filter."
      swaccess: "rw"
      hwaccess: "hro"
      fields: [
        { bits: "3:0", name: "COUNT", desc: "Set the samples count" }
      ]
    }




    // WINDOW
    { window: {
        name: "RXDATA"
        items: "1"
        validbits: "32"
        desc: '''PCM Receive data
                  '''
        swaccess: "ro"
      }
    }
  ]
}

